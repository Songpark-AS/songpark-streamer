| / 7\'7
| \ \   Xilinx Inc.
| / /
| \_\/.\   IBIS Models for ZYNQ7 IO
[IBIS ver]   4.2
[File name]   impl_1.ibs
[File Rev]   2.8
[Date]   Mon September 05 21:49:32 2022
[Source]   Derived from spice models, rev1.0, using
   hspice 2010.03-ENG2
[Notes]   Xilinx IBIS file for ZYNQ7 I/O standards.
   All models are preliminary.
   The version of IBISCHK used is ibischk5.
   Ibis models were generated using S2IBIS3.
[Disclaimer] The data in this file is derived from SPICE simulations using
                 modeling information extracted from the target process.
                 A great deal of care has been taken to provide information
                 that is accurate. This model has been verified by actual silicon
                 measurement.
[Copyright]   Copyright 2012-2016, Xilinx Inc., All rights reserved
|   Component ZYNQ7
[Component]   ZYNQ
[Manufacturer]   Xilinx Inc.
[Package]
|CLG484
|variable   typ   min   max
R_pkg   321.2m   97.8m   1199.0m
L_pkg   7.62nH   2.05nH   29.75nH
C_pkg   0.82pF   0.25pF   2.50pF
[Pin]   signal_name   model_name  R_pin  L_pin  C_pin
A1   FIXED_IO_mio[1]   LVCMOS33_F_8_PSMIO
A2   FIXED_IO_mio[2]   LVCMOS33_F_8_PSMIO
A3   FIXED_IO_mio[5]   LVCMOS33_F_8_PSMIO
A4   FIXED_IO_mio[6]   LVCMOS33_F_8_PSMIO
A5   GND   GND
A6   FIXED_IO_mio[13]   LVCMOS33_S_8_PSMIO
A7   FIXED_IO_mio[18]   LVCMOS18_F_8_PSMIO
A8   FIXED_IO_mio[20]   LVCMOS18_F_8_PSMIO
A9   FIXED_IO_mio[36]   LVCMOS18_F_8_PSMIO
A10   VCCO_MIO1_501   POWER
A11   FIXED_IO_mio[30]   LVCMOS18_F_8_PSMIO
A12   FIXED_IO_mio[28]   LVCMOS18_F_8_PSMIO
A13   FIXED_IO_mio[26]   LVCMOS18_F_8_PSMIO
A14   FIXED_IO_mio[22]   LVCMOS18_F_8_PSMIO
A15   GND   GND
A16   IO_L9P_T1_DQS_AD3P_35   NC
A17   IO_L9N_T1_DQS_AD3N_35   NC
A18   IO_L10P_T1_AD11P_35   NC
A19   IO_L10N_T1_AD11N_35   NC
A20   VCCO_35   POWER
A21   IO_L15P_T2_DQS_AD12P_35   NC
A22   IO_L15N_T2_DQS_AD12N_35   NC
B1   DDR_dm[0]   SSTL15_DCI_F_PSDDR_MS
B2   DDR_dq[2]   SSTL15_DCI_F_PSDDR_MS
B3   VCCO_MIO0_500   POWER
B4   FIXED_IO_mio[11]   LVCMOS33_S_8_PSMIO
B5   FIXED_IO_ps_porb   NC
B6   FIXED_IO_mio[14]   LVCMOS33_S_8_PSMIO
B7   FIXED_IO_mio[24]   LVCMOS18_F_8_PSMIO
B8   GND   GND
B9   FIXED_IO_mio[45]   LVCMOS18_F_8_PSMIO
B10   FIXED_IO_mio[47]   LVCMOS18_S_8_PSMIO
B11   FIXED_IO_mio[43]   LVCMOS18_F_8_PSMIO
B12   FIXED_IO_mio[34]   LVCMOS18_F_8_PSMIO
B13   VCCO_MIO1_501   POWER
B14   FIXED_IO_mio[37]   LVCMOS18_F_8_PSMIO
B15   IO_L7N_T1_AD2N_35   NC
B16   IO_L8P_T1_AD10P_35   NC
B17   IO_L8N_T1_AD10N_35   NC
B18   GND   GND
B19   IO_L13P_T2_MRCC_35   NC
B20   IO_L13N_T2_MRCC_35   NC
B21   IO_L18P_T2_AD13P_35   NC
B22   IO_L18N_T2_AD13N_35   NC
C1   GND   GND
C2   DDR_dqs_p[0]   SSTL15_DCI_F_PSDDR_MS
C3   DDR_dq[1]   SSTL15_DCI_F_PSDDR_MS
C4   FIXED_IO_mio[9]   LVCMOS33_S_8_PSMIO
C5   FIXED_IO_mio[12]   LVCMOS33_S_8_PSMIO
C6   VCCO_MIO0_500   POWER
C7   FIXED_IO_mio[32]   LVCMOS18_F_8_PSMIO
C8   FIXED_IO_mio[41]   LVCMOS18_F_8_PSMIO
C9   FIXED_IO_ps_srstb   NC
C10   FIXED_IO_mio[51]   LVCMOS18_S_8_PSMIO
C11   GND   GND
C12   FIXED_IO_mio[53]   LVCMOS18_S_8_PSMIO
C13   FIXED_IO_mio[39]   LVCMOS18_F_8_PSMIO
C14   FIXED_IO_mio[49]   LVCMOS18_S_8_PSMIO
C15   IO_L7P_T1_AD2P_35   NC
C16   VCCO_35   POWER
C17   IO_L11P_T1_SRCC_35   NC
C18   IO_L11N_T1_SRCC_35   NC
C19   IO_L12N_T1_MRCC_35   NC
C20   IO_L14N_T2_AD4N_SRCC_35   NC
C21   GND   GND
C22   IO_L16N_T2_35   NC
D1   DDR_dq[0]   SSTL15_DCI_F_PSDDR_MS
D2   DDR_dqs_n[0]   SSTL15_DCI_F_PSDDR_MS
D3   DDR_dq[3]   SSTL15_DCI_F_PSDDR_MS
D4   GND   GND
D5   FIXED_IO_mio[7]   LVCMOS33_S_8_PSMIO
D6   FIXED_IO_mio[16]   LVCMOS18_F_8_PSMIO
D7   FIXED_IO_mio[27]   LVCMOS18_F_8_PSMIO
D8   FIXED_IO_mio[42]   LVCMOS18_F_8_PSMIO
D9   VCCO_MIO1_501   POWER
D10   FIXED_IO_mio[52]   LVCMOS18_S_8_PSMIO
D11   FIXED_IO_mio[48]   LVCMOS18_S_8_PSMIO
D12   FIXED_IO_mio[46]   LVCMOS18_S_8_PSMIO
D13   FIXED_IO_mio[50]   LVCMOS18_S_8_PSMIO
D14   GND   GND
D15   IO_L3N_T0_DQS_AD1N_35   NC
D16   IO_L2P_T0_AD8P_35   NC
D17   IO_L2N_T0_AD8N_35   NC
D18   IO_L12P_T1_MRCC_35   NC
D19   VCCO_35   POWER
D20   IO_L14P_T2_AD4P_SRCC_35   NC
D21   IO_L17N_T2_AD5N_35   NC
D22   IO_L16P_T2_35   NC
E1   DDR_dq[5]   SSTL15_DCI_F_PSDDR_MS
E2   VCCO_DDR_502   POWER
E3   DDR_dq[4]   SSTL15_DCI_F_PSDDR_MS
E4   FIXED_IO_mio[4]   LVCMOS33_F_8_PSMIO
E5   FIXED_IO_mio[8]   LVCMOS33_F_8_PSMIO
E6   FIXED_IO_mio[15]   LVCMOS33_S_8_PSMIO
E7   GND   GND
E8   FIXED_IO_mio[29]   LVCMOS18_F_8_PSMIO
E9   FIXED_IO_mio[17]   LVCMOS18_F_8_PSMIO
E10   FIXED_IO_mio[19]   LVCMOS18_F_8_PSMIO
E11   FIXED_IO_mio[23]   LVCMOS18_F_8_PSMIO
E12   VCCO_MIO1_501   POWER
E13   FIXED_IO_mio[44]   LVCMOS18_F_8_PSMIO
E14   FIXED_IO_mio[40]   LVCMOS18_F_8_PSMIO
E15   IO_L3P_T0_DQS_AD1P_35   NC
E16   IO_L1N_T0_AD0N_35   NC
E17   GND   GND
E18   IO_L5N_T0_AD9N_35   NC
E19   IO_L21P_T3_DQS_AD14P_35   NC
E20   IO_L21N_T3_DQS_AD14N_35   NC
E21   IO_L17P_T2_AD5P_35   NC
E22   VCCO_35   POWER
F1   DDR_dq[7]   SSTL15_DCI_F_PSDDR_MS
F2   DDR_dq[6]   SSTL15_DCI_F_PSDDR_MS
F3   DDR_reset_n   SSTL15_F_PSDDR
F4   DDR_addr[13]   SSTL15_S_PSDDR
F5   VCCO_DDR_502   POWER
F6   FIXED_IO_mio[3]   LVCMOS33_F_8_PSMIO
F7   FIXED_IO_ps_clk   NC
F8   PS_MIO_VREF_501   NC
F9   FIXED_IO_mio[31]   LVCMOS18_F_8_PSMIO
F10   GND   GND
F11   FIXED_IO_mio[21]   LVCMOS18_F_8_PSMIO
F12   FIXED_IO_mio[25]   LVCMOS18_F_8_PSMIO
F13   FIXED_IO_mio[38]   LVCMOS18_F_8_PSMIO
F14   FIXED_IO_mio[35]   LVCMOS18_F_8_PSMIO
F15   VCCO_35   POWER
F16   IO_L1P_T0_AD0P_35   NC
F17   IO_L6N_T0_VREF_35   NC
F18   IO_L5P_T0_AD9P_35   NC
F19   IO_L20N_T3_AD6N_35   NC
F20   GND   GND
F21   sw_0[3]   LVCMOS25_S_8_HR
F22   sw_0[0]   LVCMOS25_S_8_HR
G1   DDR_dq[9]   SSTL15_DCI_F_PSDDR_MS
G2   DDR_dq[8]   SSTL15_DCI_F_PSDDR_MS
G3   GND   GND
G4   DDR_addr[14]   SSTL15_S_PSDDR
G5   DDR_addr[11]   SSTL15_S_PSDDR
G6   FIXED_IO_mio[0]   LVCMOS33_S_8_PSMIO
G7   FIXED_IO_mio[10]   LVCMOS33_S_8_PSMIO
G8   VCCPINT   POWER
G9   VCCBATT_0   LVCMOS33_F_12_HR
G10   RSVDGND   GND
G11   TCK_0   LVCMOS33_F_12_HR
G12   TMS_0   LVCMOS33_F_12_HR
G13   FIXED_IO_mio[33]   LVCMOS18_F_8_PSMIO
G14   TDO_0   LVCMOS33_F_12_HR
G15   IO_L4P_T0_35   NC
G16   IO_L4N_T0_35   NC
G17   IO_L6P_T0_35   NC
G18   VCCO_35   POWER
G19   IO_L20P_T3_AD6P_35   NC
G20   IO_L22P_T3_AD7P_35   NC
G21   IO_L22N_T3_AD7N_35   NC
G22   sw_0[1]   LVCMOS25_S_8_HR
H1   VCCO_DDR_502   POWER
H2   DDR_dqs_p[1]   SSTL15_DCI_F_PSDDR_MS
H3   DDR_dm[1]   SSTL15_DCI_F_PSDDR_MS
H4   DDR_addr[12]   SSTL15_S_PSDDR
H5   DDR_addr[9]   SSTL15_S_PSDDR
H6   GND   GND
H7   PS_DDR_VREF0_502   NC
H8   GND   GND
H9   VCCPINT   POWER
H10   VCCPLL   POWER
H11   VCCBRAM   POWER
H12   GND   GND
H13   TDI_0   LVCMOS33_F_12_HR
H14   GND   GND
H15   IO_0_34   NC
H16   GND   GND
H17   sw_0[6]   LVCMOS25_S_8_HR
H18   sw_0[5]   LVCMOS25_S_8_HR
H19   sw_0[4]   LVCMOS25_S_8_HR
H20   IO_L19N_T3_VREF_35   NC
H21   VCCO_35   POWER
H22   sw_0[2]   LVCMOS25_S_8_HR
J1   DDR_dq[14]   SSTL15_DCI_F_PSDDR_MS
J2   DDR_dqs_n[1]   SSTL15_DCI_F_PSDDR_MS
J3   DDR_addr[10]   SSTL15_S_PSDDR
J4   VCCO_DDR_502   POWER
J5   DDR_addr[8]   SSTL15_S_PSDDR
J6   DDR_addr[7]   SSTL15_S_PSDDR
J7   DDR_addr[6]   SSTL15_S_PSDDR
J8   VCCPINT   POWER
J9   GND   GND
J10   VCCBRAM   POWER
J11   GND   GND
J12   VCCINT   POWER
J13   GND   GND
J14   VCCINT   POWER
J15   IO_L1P_T0_34   NC
J16   IO_L2P_T0_34   NC
J17   IO_L2N_T0_34   NC
J18   IO_L7P_T1_34   NC
J19   GND   GND
J20   IO_L9P_T1_DQS_34   NC
J21   IO_L8P_T1_34   NC
J22   IO_L8N_T1_34   NC
K1   DDR_dq[13]   SSTL15_DCI_F_PSDDR_MS
K2   GND   GND
K3   DDR_dq[15]   SSTL15_DCI_F_PSDDR_MS
K4   DDR_addr[2]   SSTL15_S_PSDDR
K5   DDR_addr[5]   SSTL15_S_PSDDR
K6   DDR_addr[4]   SSTL15_S_PSDDR
K7   VCCO_DDR_502   POWER
K8   GND   GND
K9   VCCPAUX   POWER
K10   GND   GND
K11   VCCADC_0   NC
K12   GNDADC_0   NC
K13   VCCINT   POWER
K14   GND   GND
K15   IO_L1N_T0_34   NC
K16   PUDC_B   LVCMOS33_F_8_HR
K17   VCCO_34   POWER
K18   IO_L7N_T1_34   NC
K19   IO_L11P_T1_SRCC_34   NC
K20   IO_L11N_T1_SRCC_34   NC
K21   IO_L9N_T1_DQS_34   NC
K22   GND   GND
L1   DDR_dq[10]   SSTL15_DCI_F_PSDDR_MS
L2   DDR_dq[11]   SSTL15_DCI_F_PSDDR_MS
L3   DDR_dq[12]   SSTL15_DCI_F_PSDDR_MS
L4   DDR_addr[3]   SSTL15_S_PSDDR
L5   GND   GND
L6   DDR_ba[1]   SSTL15_S_PSDDR
L7   DDR_ba[0]   SSTL15_S_PSDDR
L8   VCCPINT   POWER
L9   GND   GND
L10   VCCAUX   POWER
L11   VP_0   NC
L12   VREFN_0   NC
L13   GND   GND
L14   VCCINT   POWER
L15   GND   GND
L16   IO_L3N_T0_DQS_34   NC
L17   IO_L4P_T0_34   NC
L18   IO_L12P_T1_MRCC_34   NC
L19   IO_L12N_T1_MRCC_34   NC
L20   VCCO_34   POWER
L21   IO_L10P_T1_34   NC
L22   IO_L10N_T1_34   NC
M1   DDR_dq[16]   SSTL15_DCI_F_PSDDR_MS
M2   DDR_dq[22]   SSTL15_DCI_F_PSDDR_MS
M3   VCCO_DDR_502   POWER
M4   DDR_addr[0]   SSTL15_S_PSDDR
M5   DDR_addr[1]   SSTL15_S_PSDDR
M6   DDR_ba[2]   SSTL15_S_PSDDR
M7   FIXED_IO_ddr_vrn   NC
M8   GND   GND
M9   VCCPAUX   POWER
M10   GND   GND
M11   VREFP_0   NC
M12   VN_0   NC
M13   VCCINT   POWER
M14   GND   GND
M15   sw_0[7]   LVCMOS25_S_8_HR
M16   IO_L6N_T0_VREF_34   NC
M17   IO_L4N_T0_34   NC
M18   GND   GND
M19   IO_L13P_T2_MRCC_34   NC
M20   IO_L13N_T2_MRCC_34   NC
M21   IO_L15P_T2_DQS_34   NC
M22   IO_L15N_T2_DQS_34   NC
N1   GND   GND
N2   DDR_dqs_p[2]   SSTL15_DCI_F_PSDDR_MS
N3   DDR_dq[18]   SSTL15_DCI_F_PSDDR_MS
N4   DDR_ck_p   SSTL15_F_PSDDR
N5   DDR_ck_n   SSTL15_F_PSDDR
N6   VCCO_DDR_502   POWER
N7   FIXED_IO_ddr_vrp   NC
N8   VCCPINT   POWER
N9   GND   GND
N10   VCCAUX   POWER
N11   DXP_0   NC
N12   DXN_0   NC
N13   GND   GND
N14   VCCINT   POWER
N15   btnl_0   LVCMOS25_S_8_HR
N16   VCCO_34   POWER
N17   IO_L5P_T0_34   NC
N18   IO_L5N_T0_34   NC
N19   IO_L14P_T2_SRCC_34   NC
N20   IO_L14N_T2_SRCC_34   NC
N21   GND   GND
N22   IO_L16P_T2_34   NC
P1   DDR_dm[2]   SSTL15_DCI_F_PSDDR_MS
P2   DDR_dqs_n[2]   SSTL15_DCI_F_PSDDR_MS
P3   DDR_cas_n   SSTL15_S_PSDDR
P4   GND   GND
P5   DDR_odt   SSTL15_S_PSDDR
P6   DDR_cs_n   SSTL15_S_PSDDR
P7   PS_DDR_VREF1_502   NC
P8   GND   GND
P9   VCCPAUX   POWER
P10   GND   GND
P11   VCCAUX   POWER
P12   GND   GND
P13   VCCINT   POWER
P14   GND   GND
P15   IO_L19N_T3_VREF_34   NC
P16   btnc_0   LVCMOS25_S_8_HR
P17   IO_L20P_T3_34   NC
P18   IO_L20N_T3_34   NC
P19   VCCO_34   POWER
P20   IO_L18P_T2_34   NC
P21   IO_L18N_T2_34   NC
P22   IO_L16N_T2_34   NC
R1   DDR_dq[23]   SSTL15_DCI_F_PSDDR_MS
R2   VCCO_DDR_502   POWER
R3   DDR_dq[20]   SSTL15_DCI_F_PSDDR_MS
R4   DDR_we_n   SSTL15_S_PSDDR
R5   DDR_ras_n   SSTL15_S_PSDDR
R6   sync_en_out_0   LVCMOS33_S_12_HR
R7   IO_0_13   NC
R8   VCCPINT   POWER
R9   GND   GND
R10   VCCAUX   POWER
R11   GND   GND
R12   VCCO_0   POWER
R13   GND   GND
R14   VCCINT   POWER
R15   IO_25_34   NC
R16   btnd_0   LVCMOS25_S_8_HR
R17   GND   GND
R18   btnr_0   LVCMOS25_S_8_HR
R19   IO_L22P_T3_34   NC
R20   IO_L17P_T2_34   NC
R21   IO_L17N_T2_34   NC
R22   VCCO_34   POWER
T1   DDR_dq[19]   SSTL15_DCI_F_PSDDR_MS
T2   DDR_dq[21]   SSTL15_DCI_F_PSDDR_MS
T3   DDR_dq[17]   SSTL15_DCI_F_PSDDR_MS
T4   IO_L20P_T3_13   NC
T5   VCCO_13   POWER
T6   tsync_out_0   LVCMOS33_S_12_HR
T7   RSVDVCC1   NC
T8   RSVDVCC2   NC
T9   VCCPAUX   POWER
T10   RSVDVCC3   NC
T11   PROGRAM_B_0   LVCMOS33_F_12_HR
T12   DONE_0   LVCMOS33_F_12_HR
T13   CFGBVS_0   LVCMOS33_F_12_HR
T14   INIT_B_0   LVCMOS33_F_12_HR
T15   VCCO_34   POWER
T16   IO_L21P_T3_DQS_34   NC
T17   IO_L21N_T3_DQS_34   NC
T18   btnu_0   LVCMOS25_S_8_HR
T19   IO_L22N_T3_34   NC
T20   GND   GND
T21   led_0[1]   LVCMOS33_S_12_HR
T22   led_0[0]   LVCMOS33_S_12_HR
U1   DDR_dq[25]   SSTL15_DCI_F_PSDDR_MS
U2   DDR_dq[27]   SSTL15_DCI_F_PSDDR_MS
U3   GND   GND
U4   IO_L20N_T3_13   NC
U5   mclk1_0   LVCMOS33_S_12_HR
U6   serial_data_out1_0   LVCMOS33_S_12_HR
U7   IO_25_13   NC
U8   VCCO_13   POWER
U9   RES   LVCMOS33_S_12_HR
U10   DC   LVCMOS33_S_12_HR
U11   VBAT   LVCMOS33_S_12_HR
U12   VDD   LVCMOS33_S_12_HR
U13   GND   GND
U14   led_0[7]   LVCMOS33_S_12_HR
U15   IO_L15P_T2_DQS_33   NC
U16   IO_L15N_T2_DQS_33   NC
U17   IO_L16P_T2_33   NC
U18   VCCO_33   POWER
U19   led_0[6]   LVCMOS33_S_12_HR
U20   IO_L5P_T0_33   NC
U21   led_0[3]   LVCMOS33_S_12_HR
U22   led_0[2]   LVCMOS33_S_12_HR
V1   VCCO_DDR_502   POWER
V2   DDR_dqs_p[3]   SSTL15_DCI_F_PSDDR_MS
V3   DDR_cke   SSTL15_S_PSDDR
V4   bclk1_0   LVCMOS33_S_12_HR
V5   serial_data_in1_0   LVCMOS33_S_8_HR
V6   GND   GND
V7   ctrl_sw_out_0   LVCMOS33_S_12_HR
V8   phy_txd_0[2]   LVCMOS33_S_12_HR
V9   phy_txd_0[0]   LVCMOS33_S_12_HR
V10   phy_txd_0[1]   LVCMOS33_S_12_HR
V11   VCCO_13   POWER
V12   IO_L4P_T0_13   NC
V13   IO_L20P_T3_33   NC
V14   IO_L19P_T3_33   NC
V15   IO_L19N_T3_VREF_33   NC
V16   GND   GND
V17   IO_L16N_T2_33   NC
V18   IO_L6P_T0_33   NC
V19   IO_L6N_T0_VREF_33   NC
V20   IO_L5N_T0_33   NC
V21   VCCO_33   POWER
V22   led_0[4]   LVCMOS33_S_12_HR
W1   DDR_dq[28]   SSTL15_DCI_F_PSDDR_MS
W2   DDR_dqs_n[3]   SSTL15_DCI_F_PSDDR_MS
W3   DDR_dq[30]   SSTL15_DCI_F_PSDDR_MS
W4   VCCO_13   POWER
W5   IO_L24N_T3_13   NC
W6   IO_L24P_T3_13   NC
W7   lrclk1_0   LVCMOS33_S_12_HR
W8   phy_txd_0[3]   LVCMOS33_S_12_HR
W9   GND   GND
W10   phy_rx_clk_0   LVCMOS33_S_8_HR
W11   phy_tx_clk_0   LVCMOS33_S_12_HR
W12   IO_L4N_T0_13   NC
W13   IO_L20N_T3_33   NC
W14   VCCO_33   POWER
W15   IO_L21P_T3_DQS_33   NC
W16   IO_L14P_T2_SRCC_33   NC
W17   IO_L13P_T2_MRCC_33   NC
W18   IO_L13N_T2_MRCC_33   NC
W19   GND   GND
W20   IO_L4P_T0_33   NC
W21   IO_L4N_T0_33   NC
W22   led_0[5]   LVCMOS33_S_12_HR
Y1   DDR_dq[31]   SSTL15_DCI_F_PSDDR_MS
Y2   GND   GND
Y3   DDR_dq[29]   SSTL15_DCI_F_PSDDR_MS
Y4   phy_mdio_0   LVCMOS33_S_12_HR
Y5   adau1761_cdata_0   LVCMOS33_S_12_HR
Y6   adau1761_lrclk_0   LVCMOS33_S_8_HR
Y7   VCCO_13   POWER
Y8   adau1761_dac_sdata_0   LVCMOS33_S_12_HR
Y9   clk_100_in   LVCMOS33_S_8_HR
Y10   phy_rxd_0[1]   LVCMOS33_S_8_HR
Y11   IO_L10P_T1_13   NC
Y12   GND   GND
Y13   IO_L23P_T3_33   NC
Y14   IO_L22P_T3_33   NC
Y15   IO_L21N_T3_DQS_33   NC
Y16   IO_L14N_T2_SRCC_33   NC
Y17   VCCO_33   POWER
Y18   IO_L12P_T1_MRCC_33   NC
Y19   IO_L11P_T1_SRCC_33   NC
Y20   IO_L9P_T1_DQS_33   NC
Y21   IO_L9N_T1_DQS_33   NC
Y22   GND   GND
AA1   DDR_dq[26]   SSTL15_DCI_F_PSDDR_MS
AA2   DDR_dm[3]   SSTL15_DCI_F_PSDDR_MS
AA3   DDR_dq[24]   SSTL15_DCI_F_PSDDR_MS
AA4   phy_mdc_0   LVCMOS33_S_12_HR
AA5   GND   GND
AA6   adau1761_bclk_0   LVCMOS33_S_8_HR
AA7   adau1761_adc_sdata_0   LVCMOS33_S_8_HR
AA8   phy_int_n_0   LVCMOS33_S_8_HR
AA9   phy_rxd_0[3]   LVCMOS33_S_8_HR
AA10   VCCO_13   POWER
AA11   phy_rx_ctl_0   LVCMOS33_S_8_HR
AA12   SDIN   LVCMOS33_S_12_HR
AA13   IO_L23N_T3_33   NC
AA14   IO_L22N_T3_33   NC
AA15   GND   GND
AA16   IO_L18P_T2_33   NC
AA17   IO_L17P_T2_33   NC
AA18   IO_L12N_T1_MRCC_33   NC
AA19   IO_L11N_T1_SRCC_33   NC
AA20   VCCO_33   POWER
AA21   IO_L8P_T1_33   NC
AA22   IO_L7P_T1_33   NC
AB1   adau1761_clatchn_0   LVCMOS33_S_12_HR
AB2   adau1761_mclk   LVCMOS33_S_12_HR
AB3   VCCO_13   POWER
AB4   adau1761_cclk_0   LVCMOS33_S_12_HR
AB5   adau1761_cout_0   LVCMOS33_S_8_HR
AB6   phy_tx_ctl_0   LVCMOS33_S_12_HR
AB7   phy_reset_n_0   LVCMOS33_S_12_HR
AB8   GND   GND
AB9   phy_rxd_0[2]   LVCMOS33_S_8_HR
AB10   phy_rxd_0[0]   LVCMOS33_S_8_HR
AB11   phy_pme_n_0   LVCMOS33_S_8_HR
AB12   SCLK   LVCMOS33_S_12_HR
AB13   VCCO_33   POWER
AB14   IO_L24P_T3_33   NC
AB15   IO_L24N_T3_33   NC
AB16   IO_L18N_T2_33   NC
AB17   IO_L17N_T2_33   NC
AB18   GND   GND
AB19   IO_L10P_T1_33   NC
AB20   IO_L10N_T1_33   NC
AB21   IO_L8N_T1_33   NC
AB22   IO_L7N_T1_33   NC
[Package Model]   xc7z020_clg484
[Diff Pin]   inv_pin   vdiff   tdelay_typ   tdelay_min   tdelay_max
C2   D2   100mv   0   0   0
| DDR_dqs_p[0]   DIFF_SSTL15_T_DCI_F_PSDDR_P SSTL15_DCI_F_PSDDR_IN50_I
H2   J2   100mv   0   0   0
| DDR_dqs_p[1]   DIFF_SSTL15_T_DCI_F_PSDDR_P SSTL15_DCI_F_PSDDR_IN50_I
N2   P2   100mv   0   0   0
| DDR_dqs_p[2]   DIFF_SSTL15_T_DCI_F_PSDDR_P SSTL15_DCI_F_PSDDR_IN50_I
N4   N5   100mv   0   0   0
| DDR_ck_p   DIFF_SSTL15_F_PSDDR_P SSTL15_F_PSDDR
V2   W2   100mv   0   0   0
| DDR_dqs_p[3]   DIFF_SSTL15_T_DCI_F_PSDDR_P SSTL15_DCI_F_PSDDR_IN50_I
[Model Selector]   SSTL15_DCI_F_PSDDR_MS
SSTL15_DCI_F_PSDDR_IN40_I   Input
SSTL15_DCI_F_PSDDR_IN50_I   Input
SSTL15_DCI_F_PSDDR_IN60_I   Input
SSTL15_DCI_F_PSDDR_O   Output
[Define Package Model]   xc7z020_clg484
[Manufacturer]   Xilinx Inc.
[OEM]   Xilinx
[Description]   484 ball organic wirebond
|[Number of Sections]   1
[Number of Pins]   367
[Pin Numbers]
|[Pin Name]  Net Number   Net Name   Net's All Pins
K11   | 1   VCCADC_0   K11
L10   | 2   VCCAUX   L10
   |N10
   |P11
   |R10
G9   | 3   VCCBATT_0   G9
H11   | 4   VCCBRAM   H11
   |J10
J12   | 5   VCCINT   J12
   |J14
   |K13
   |L14
   |M13
   |N14
   |P13
   |R14
R12   | 6   VCCO_0   R12
AA10   | 7   VCCO_13   AA10
   |AB3
   |T5
   |U8
   |V11
   |W4
   |Y7
AA20   | 8   VCCO_33   AA20
   |AB13
   |U18
   |V21
   |W14
   |Y17
K17   | 9   VCCO_34   K17
   |L20
   |N16
   |P19
   |R22
   |T15
A20   | 10   VCCO_35   A20
   |C16
   |D19
   |E22
   |F15
   |G18
   |H21
E2   | 11   VCCO_DDR   E2
   |F5
   |H1
   |J4
   |K7
   |M3
   |N6
   |R2
   |V1
B3   | 12   VCCO_P0   B3
   |C6
A10   | 13   VCCO_P1   A10
   |B13
   |D9
   |E12
K9   | 14   VCCPAUX   K9
   |M9
   |P9
   |T9
G8   | 15   VCCPINT   G8
   |H9
   |J8
   |L8
   |N8
   |R8
H10   | 16   VCCPLL   H10
G10   | 17   CCLK_0   G10
T13   | 18   CFGBVS_0   T13
T12   | 19   DONE_0   T12
N12   | 20   DXN_0   N12
N11   | 21   DXP_0   N11
T14   | 22   INIT_B_0   T14
R7   | 23   IO_0_13   R7
U19   | 24   IO_0_33   U19
H15   | 25   IO_0_34   H15
H17   | 26   IO_0_35   H17
U7   | 27   IO_25_13   U7
U14   | 28   IO_25_33   U14
R15   | 29   IO_25_34   R15
H18   | 30   IO_25_35   H18
V9   | 31   IO_L1N_T0_13   V9
U21   | 32   IO_L1N_T0_33   U21
E16   | 33   IO_L1N_T0_AD0N_35   E16
K15   | 34   IO_L1N_T0_D01_DIN_34   K15
V10   | 35   IO_L1P_T0_13   V10
T21   | 36   IO_L1P_T0_33   T21
F16   | 37   IO_L1P_T0_AD0P_35   F16
J15   | 38   IO_L1P_T0_D00_MOSI_34   J15
W8   | 39   IO_L2N_T0_13   W8
U22   | 40   IO_L2N_T0_33   U22
D17   | 41   IO_L2N_T0_AD8N_35   D17
J17   | 42   IO_L2N_T0_D03_34   J17
V8   | 43   IO_L2P_T0_13   V8
T22   | 44   IO_L2P_T0_33   T22
D16   | 45   IO_L2P_T0_AD8P_35   D16
J16   | 46   IO_L2P_T0_D02_34   J16
W10   | 47   IO_L3N_T0_DQS_13   W10
W22   | 48   IO_L3N_T0_DQS_33   W22
D15   | 49   IO_L3N_T0_DQS_AD1N_35   D15
L16   | 50   IO_L3N_T0_DQS_EMCCLK_34   L16
W11   | 51   IO_L3P_T0_DQS_13   W11
V22   | 52   IO_L3P_T0_DQS_33   V22
E15   | 53   IO_L3P_T0_DQS_AD1P_35   E15
K16   | 54   IO_L3P_T0_DQS_PUDC_B_34   K16
W12   | 55   IO_L4N_T0_13   W12
W21   | 56   IO_L4N_T0_33   W21
G16   | 57   IO_L4N_T0_35   G16
M17   | 58   IO_L4N_T0_D05_34   M17
V12   | 59   IO_L4P_T0_13   V12
W20   | 60   IO_L4P_T0_33   W20
G15   | 61   IO_L4P_T0_35   G15
L17   | 62   IO_L4P_T0_D04_34   L17
U11   | 63   IO_L5N_T0_13   U11
V20   | 64   IO_L5N_T0_33   V20
E18   | 65   IO_L5N_T0_AD9N_35   E18
N18   | 66   IO_L5N_T0_D07_34   N18
U12   | 67   IO_L5P_T0_13   U12
U20   | 68   IO_L5P_T0_33   U20
F18   | 69   IO_L5P_T0_AD9P_35   F18
N17   | 70   IO_L5P_T0_D06_34   N17
M16   | 71   IO_L6N_T0_D08_VREF_34   M16
U9   | 72   IO_L6N_T0_VREF_13   U9
V19   | 73   IO_L6N_T0_VREF_33   V19
F17   | 74   IO_L6N_T0_VREF_35   F17
U10   | 75   IO_L6P_T0_13   U10
V18   | 76   IO_L6P_T0_33   V18
G17   | 77   IO_L6P_T0_35   G17
M15   | 78   IO_L6P_T0_FCS_B_34   M15
AB12   | 79   IO_L7N_T1_13   AB12
AB22   | 80   IO_L7N_T1_33   AB22
B15   | 81   IO_L7N_T1_AD2N_35   B15
K18   | 82   IO_L7N_T1_D10_34   K18
AA12   | 83   IO_L7P_T1_13   AA12
AA22   | 84   IO_L7P_T1_33   AA22
C15   | 85   IO_L7P_T1_AD2P_35   C15
J18   | 86   IO_L7P_T1_D09_34   J18
AB11   | 87   IO_L8N_T1_13   AB11
AB21   | 88   IO_L8N_T1_33   AB21
B17   | 89   IO_L8N_T1_AD10N_35   B17
J22   | 90   IO_L8N_T1_D12_34   J22
AA11   | 91   IO_L8P_T1_13   AA11
AA21   | 92   IO_L8P_T1_33   AA21
B16   | 93   IO_L8P_T1_AD10P_35   B16
J21   | 94   IO_L8P_T1_D11_34   J21
AB9   | 95   IO_L9N_T1_DQS_13   AB9
Y21   | 96   IO_L9N_T1_DQS_33   Y21
A17   | 97   IO_L9N_T1_DQS_AD3N_35   A17
K21   | 98   IO_L9N_T1_DQS_D13_34   K21
AB10   | 99   IO_L9P_T1_DQS_13   AB10
Y20   | 100   IO_L9P_T1_DQS_33   Y20
J20   | 101   IO_L9P_T1_DQS_34   J20
A16   | 102   IO_L9P_T1_DQS_AD3P_35   A16
Y10   | 103   IO_L10N_T1_13   Y10
AB20   | 104   IO_L10N_T1_33   AB20
A19   | 105   IO_L10N_T1_AD11N_35   A19
L22   | 106   IO_L10N_T1_D15_34   L22
Y11   | 107   IO_L10P_T1_13   Y11
AB19   | 108   IO_L10P_T1_33   AB19
A18   | 109   IO_L10P_T1_AD11P_35   A18
L21   | 110   IO_L10P_T1_D14_34   L21
AA8   | 111   IO_L11N_T1_SRCC_13   AA8
AA19   | 112   IO_L11N_T1_SRCC_33   AA19
K20   | 113   IO_L11N_T1_SRCC_34   K20
C18   | 114   IO_L11N_T1_SRCC_35   C18
AA9   | 115   IO_L11P_T1_SRCC_13   AA9
Y19   | 116   IO_L11P_T1_SRCC_33   Y19
K19   | 117   IO_L11P_T1_SRCC_34   K19
C17   | 118   IO_L11P_T1_SRCC_35   C17
Y8   | 119   IO_L12N_T1_MRCC_13   Y8
AA18   | 120   IO_L12N_T1_MRCC_33   AA18
L19   | 121   IO_L12N_T1_MRCC_34   L19
C19   | 122   IO_L12N_T1_MRCC_35   C19
Y9   | 123   IO_L12P_T1_MRCC_13   Y9
Y18   | 124   IO_L12P_T1_MRCC_33   Y18
L18   | 125   IO_L12P_T1_MRCC_34   L18
D18   | 126   IO_L12P_T1_MRCC_35   D18
Y5   | 127   IO_L13N_T2_MRCC_13   Y5
W18   | 128   IO_L13N_T2_MRCC_33   W18
M20   | 129   IO_L13N_T2_MRCC_34   M20
B20   | 130   IO_L13N_T2_MRCC_35   B20
Y6   | 131   IO_L13P_T2_MRCC_13   Y6
W17   | 132   IO_L13P_T2_MRCC_33   W17
M19   | 133   IO_L13P_T2_MRCC_34   M19
B19   | 134   IO_L13P_T2_MRCC_35   B19
C20   | 135   IO_L14N_T2_AD4N_SRCC_35   C20
AA6   | 136   IO_L14N_T2_SRCC_13   AA6
Y16   | 137   IO_L14N_T2_SRCC_33   Y16
N20   | 138   IO_L14N_T2_SRCC_34   N20
D20   | 139   IO_L14P_T2_AD4P_SRCC_35   D20
AA7   | 140   IO_L14P_T2_SRCC_13   AA7
W16   | 141   IO_L14P_T2_SRCC_33   W16
N19   | 142   IO_L14P_T2_SRCC_34   N19
AB1   | 143   IO_L15N_T2_DQS_13   AB1
U16   | 144   IO_L15N_T2_DQS_33   U16
A22   | 145   IO_L15N_T2_DQS_AD12N_35   A22
M22   | 146   IO_L15N_T2_DQS_DOUT_CSO_B_34   M22
AB2   | 147   IO_L15P_T2_DQS_13   AB2
U15   | 148   IO_L15P_T2_DQS_33   U15
A21   | 149   IO_L15P_T2_DQS_AD12P_35   A21
M21   | 150   IO_L15P_T2_DQS_RDWR_B_34   M21
AB4   | 151   IO_L16N_T2_13   AB4
V17   | 152   IO_L16N_T2_33   V17
C22   | 153   IO_L16N_T2_35   C22
P22   | 154   IO_L16N_T2_A15_D31_34   P22
AB5   | 155   IO_L16P_T2_13   AB5
U17   | 156   IO_L16P_T2_33   U17
D22   | 157   IO_L16P_T2_35   D22
N22   | 158   IO_L16P_T2_CSI_B_34   N22
AB6   | 159   IO_L17N_T2_13   AB6
AB17   | 160   IO_L17N_T2_33   AB17
R21   | 161   IO_L17N_T2_A13_D29_34   R21
D21   | 162   IO_L17N_T2_AD5N_35   D21
AB7   | 163   IO_L17P_T2_13   AB7
AA17   | 164   IO_L17P_T2_33   AA17
R20   | 165   IO_L17P_T2_A14_D30_34   R20
E21   | 166   IO_L17P_T2_AD5P_35   E21
AA4   | 167   IO_L18N_T2_13   AA4
AB16   | 168   IO_L18N_T2_33   AB16
P21   | 169   IO_L18N_T2_A11_D27_34   P21
B22   | 170   IO_L18N_T2_AD13N_35   B22
Y4   | 171   IO_L18P_T2_13   Y4
AA16   | 172   IO_L18P_T2_33   AA16
P20   | 173   IO_L18P_T2_A12_D28_34   P20
B21   | 174   IO_L18P_T2_AD13P_35   B21
P15   | 175   IO_L19N_T3_A09_D25_VREF_34   P15
T6   | 176   IO_L19N_T3_VREF_13   T6
V15   | 177   IO_L19N_T3_VREF_33   V15
H20   | 178   IO_L19N_T3_VREF_35   H20
R6   | 179   IO_L19P_T3_13   R6
V14   | 180   IO_L19P_T3_33   V14
H19   | 181   IO_L19P_T3_35   H19
N15   | 182   IO_L19P_T3_A10_D26_34   N15
U4   | 183   IO_L20N_T3_13   U4
W13   | 184   IO_L20N_T3_33   W13
P18   | 185   IO_L20N_T3_A07_D23_34   P18
F19   | 186   IO_L20N_T3_AD6N_35   F19
T4   | 187   IO_L20P_T3_13   T4
V13   | 188   IO_L20P_T3_33   V13
P17   | 189   IO_L20P_T3_A08_D24_34   P17
G19   | 190   IO_L20P_T3_AD6P_35   G19
V4   | 191   IO_L21N_T3_DQS_13   V4
Y15   | 192   IO_L21N_T3_DQS_33   Y15
T17   | 193   IO_L21N_T3_DQS_A06_D22_34   T17
E20   | 194   IO_L21N_T3_DQS_AD14N_35   E20
V5   | 195   IO_L21P_T3_DQS_13   V5
W15   | 196   IO_L21P_T3_DQS_33   W15
T16   | 197   IO_L21P_T3_DQS_34   T16
E19   | 198   IO_L21P_T3_DQS_AD14P_35   E19
U5   | 199   IO_L22N_T3_13   U5
AA14   | 200   IO_L22N_T3_33   AA14
T19   | 201   IO_L22N_T3_A04_D20_34   T19
G21   | 202   IO_L22N_T3_AD7N_35   G21
U6   | 203   IO_L22P_T3_13   U6
Y14   | 204   IO_L22P_T3_33   Y14
R19   | 205   IO_L22P_T3_A05_D21_34   R19
G20   | 206   IO_L22P_T3_AD7P_35   G20
W7   | 207   IO_L23N_T3_13   W7
AA13   | 208   IO_L23N_T3_33   AA13
F22   | 209   IO_L23N_T3_35   F22
T18   | 210   IO_L23N_T3_A02_D18_34   T18
V7   | 211   IO_L23P_T3_13   V7
Y13   | 212   IO_L23P_T3_33   Y13
F21   | 213   IO_L23P_T3_35   F21
R18   | 214   IO_L23P_T3_A03_D19_34   R18
W5   | 215   IO_L24N_T3_13   W5
AB15   | 216   IO_L24N_T3_33   AB15
R16   | 217   IO_L24N_T3_A00_D16_34   R16
G22   | 218   IO_L24N_T3_AD15N_35   G22
W6   | 219   IO_L24P_T3_13   W6
AB14   | 220   IO_L24P_T3_33   AB14
P16   | 221   IO_L24P_T3_A01_D17_34   P16
H22   | 222   IO_L24P_T3_AD15P_35   H22
T10   | 223   M0_0   T10
T8   | 224   M1_0   T8
T7   | 225   M2_0   T7
T11   | 226   PROGRAM_B_0   T11
F7   | 227   PS_CLK   F7
M4   | 228   PS_DDR_A0   M4
M5   | 229   PS_DDR_A1   M5
K4   | 230   PS_DDR_A2   K4
L4   | 231   PS_DDR_A3   L4
K6   | 232   PS_DDR_A4   K6
K5   | 233   PS_DDR_A5   K5
J7   | 234   PS_DDR_A6   J7
J6   | 235   PS_DDR_A7   J6
J5   | 236   PS_DDR_A8   J5
H5   | 237   PS_DDR_A9   H5
J3   | 238   PS_DDR_A10   J3
G5   | 239   PS_DDR_A11   G5
H4   | 240   PS_DDR_A12   H4
F4   | 241   PS_DDR_A13   F4
G4   | 242   PS_DDR_A14   G4
L7   | 243   PS_DDR_BA0   L7
L6   | 244   PS_DDR_BA1   L6
M6   | 245   PS_DDR_BA2   M6
P3   | 246   PS_DDR_CAS_B   P3
V3   | 247   PS_DDR_CKE   V3
N5   | 248   PS_DDR_CKN   N5
N4   | 249   PS_DDR_CKP   N4
P6   | 250   PS_DDR_CS_B   P6
B1   | 251   PS_DDR_DM0   B1
H3   | 252   PS_DDR_DM1   H3
P1   | 253   PS_DDR_DM2   P1
AA2   | 254   PS_DDR_DM3   AA2
D1   | 255   PS_DDR_DQ0   D1
C3   | 256   PS_DDR_DQ1   C3
B2   | 257   PS_DDR_DQ2   B2
D3   | 258   PS_DDR_DQ3   D3
E3   | 259   PS_DDR_DQ4   E3
E1   | 260   PS_DDR_DQ5   E1
F2   | 261   PS_DDR_DQ6   F2
F1   | 262   PS_DDR_DQ7   F1
G2   | 263   PS_DDR_DQ8   G2
G1   | 264   PS_DDR_DQ9   G1
L1   | 265   PS_DDR_DQ10   L1
L2   | 266   PS_DDR_DQ11   L2
L3   | 267   PS_DDR_DQ12   L3
K1   | 268   PS_DDR_DQ13   K1
J1   | 269   PS_DDR_DQ14   J1
K3   | 270   PS_DDR_DQ15   K3
M1   | 271   PS_DDR_DQ16   M1
T3   | 272   PS_DDR_DQ17   T3
N3   | 273   PS_DDR_DQ18   N3
T1   | 274   PS_DDR_DQ19   T1
R3   | 275   PS_DDR_DQ20   R3
T2   | 276   PS_DDR_DQ21   T2
M2   | 277   PS_DDR_DQ22   M2
R1   | 278   PS_DDR_DQ23   R1
AA3   | 279   PS_DDR_DQ24   AA3
U1   | 280   PS_DDR_DQ25   U1
AA1   | 281   PS_DDR_DQ26   AA1
U2   | 282   PS_DDR_DQ27   U2
W1   | 283   PS_DDR_DQ28   W1
Y3   | 284   PS_DDR_DQ29   Y3
W3   | 285   PS_DDR_DQ30   W3
Y1   | 286   PS_DDR_DQ31   Y1
D2   | 287   PS_DDR_DQS_N0   D2
J2   | 288   PS_DDR_DQS_N1   J2
P2   | 289   PS_DDR_DQS_N2   P2
W2   | 290   PS_DDR_DQS_N3   W2
C2   | 291   PS_DDR_DQS_P0   C2
H2   | 292   PS_DDR_DQS_P1   H2
N2   | 293   PS_DDR_DQS_P2   N2
V2   | 294   PS_DDR_DQS_P3   V2
F3   | 295   PS_DDR_DRST_B   F3
P5   | 296   PS_DDR_ODT   P5
R5   | 297   PS_DDR_RAS_B   R5
H7   | 298   PS_DDR_VREF0   H7
P7   | 299   PS_DDR_VREF1   P7
M7   | 300   PS_DDR_VRN   M7
N7   | 301   PS_DDR_VRP   N7
R4   | 302   PS_DDR_WE_B   R4
G6   | 303   PS_MIO0   G6
A1   | 304   PS_MIO1   A1
A2   | 305   PS_MIO2   A2
F6   | 306   PS_MIO3   F6
E4   | 307   PS_MIO4   E4
A3   | 308   PS_MIO5   A3
A4   | 309   PS_MIO6   A4
D5   | 310   PS_MIO7   D5
E5   | 311   PS_MIO8   E5
C4   | 312   PS_MIO9   C4
G7   | 313   PS_MIO10   G7
B4   | 314   PS_MIO11   B4
C5   | 315   PS_MIO12   C5
A6   | 316   PS_MIO13   A6
B6   | 317   PS_MIO14   B6
E6   | 318   PS_MIO15   E6
D6   | 319   PS_MIO16   D6
E9   | 320   PS_MIO17   E9
A7   | 321   PS_MIO18   A7
E10   | 322   PS_MIO19   E10
A8   | 323   PS_MIO20   A8
F11   | 324   PS_MIO21   F11
A14   | 325   PS_MIO22   A14
E11   | 326   PS_MIO23   E11
B7   | 327   PS_MIO24   B7
F12   | 328   PS_MIO25   F12
A13   | 329   PS_MIO26   A13
D7   | 330   PS_MIO27   D7
A12   | 331   PS_MIO28   A12
E8   | 332   PS_MIO29   E8
A11   | 333   PS_MIO30   A11
F9   | 334   PS_MIO31   F9
C7   | 335   PS_MIO32   C7
G13   | 336   PS_MIO33   G13
B12   | 337   PS_MIO34   B12
F14   | 338   PS_MIO35   F14
A9   | 339   PS_MIO36   A9
B14   | 340   PS_MIO37   B14
F13   | 341   PS_MIO38   F13
C13   | 342   PS_MIO39   C13
E14   | 343   PS_MIO40   E14
C8   | 344   PS_MIO41   C8
D8   | 345   PS_MIO42   D8
B11   | 346   PS_MIO43   B11
E13   | 347   PS_MIO44   E13
B9   | 348   PS_MIO45   B9
D12   | 349   PS_MIO46   D12
B10   | 350   PS_MIO47   B10
D11   | 351   PS_MIO48   D11
C14   | 352   PS_MIO49   C14
D13   | 353   PS_MIO50   D13
C10   | 354   PS_MIO51   C10
D10   | 355   PS_MIO52   D10
C12   | 356   PS_MIO53   C12
B5   | 357   PS_POR_B   B5
C9   | 358   PS_SRST_B   C9
F8   | 359   PS_VREF_MIO_15   F8
G11   | 360   TCK_0   G11
H13   | 361   TDI_0   H13
G14   | 362   TDO_0   G14
G12   | 363   TMS_0   G12
M12   | 364   VN_0   M12
L11   | 365   VP_0   L11
L12   | 366   VREFN_0   L12
M11   | 367   VREFP_0   M11
[Model Data]
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[End Model Data]
[End Package Model]
| Models and submodels in the file (15): LVCMOS18_F_8_PSMIO (I/O), LVCMOS18_S_8_PSMIO (I/O), LVCMOS25_S_8_HR (I/O), LVCMOS33_F_12_HR (I/O), LVCMOS33_F_8_HR (I/O), LVCMOS33_F_8_PSMIO (I/O), LVCMOS33_S_12_HR (I/O), LVCMOS33_S_8_HR (I/O), LVCMOS33_S_8_PSMIO (I/O), SSTL15_DCI_F_PSDDR_IN40_I (Input), SSTL15_DCI_F_PSDDR_IN50_I (Input), SSTL15_DCI_F_PSDDR_IN60_I (Input), SSTL15_DCI_F_PSDDR_O (Output), SSTL15_F_PSDDR (I/O), SSTL15_S_PSDDR (I/O)
